# Ansys Electronics Desktop project, version 2019.3
materials:
  perfect conductor: conductivity=1e+30
  silicon1: permittivity=11.45
  vacuum: permittivity=1
  thin_layer_eps_r_num: permittivity=10

design hfss_design (HFSS, Eigenmode, model units um)
variables:
  sub_Y = sub_X
  sub_Z = 550um
  sub_X = 2000um
  FC_z = 10um
  sc_z = 0.15um
  qb_r = cp_r_crit+qb_r_delta
  qb_gap = 30um
  ro_r = 1e+6*(ro_alpha*(ro_r_crit+5um)+(1-ro_alpha)*(qb_r-10um)) um
  ro_angle = cp_angle
  cp_r = cp_alpha*(cp_r_crit+5um)+(1-cp_alpha)*(qb_r-10um)
  ro_alpha = cp_alpha
  cp_angle = 60deg
  cp_gap = 30um
  ro_r_crit = ro_gap/sin(ro_angle/2)
  cp_alpha = 0.5
  cp_r_crit = cp_gap/sin(cp_angle/2)
  ro_gap = cp_gap
  spacing_angle = (360 deg - 4 * cp_angle - ro_angle) /5
  lossy_layer_thickness = 0.1um
  JJ_w = 5um
  L_JJ = 9.2nH
  qb_r_delta = 140um
geometry:
  sub_bot [silicon1] = box(corner=(-sub_X/2, -sub_Y/2, -sub_Z), size=(sub_X, sub_Y, sub_Z))
  sub_top [silicon1] = sub_bot.duplicate_along_line(step=(0um, 0um, sub_Z+FC_z), total=2)
  GND_top [perfect conductor] = object_from(sub_top.face(2 of 6))
  coordinate_system RelativeCS1 = origin=(0um, 0um, FC_z) Euler Angle ZYZ phi=0deg theta=0deg psi=0deg
  Region [vacuum] = region(+X=0 percentage offset, -X=0 percentage offset, +Y=0 percentage offset, -Y=0 percentage offset, +Z=500um absolute offset, -Z=500um absolute offset) in RelativeCS1
  Circle2 = circle(normal=Z, centre=(0um, 0um, 0um), radius=qb_r+qb_gap) in RelativeCS1
  GND_top.subtract(Circle2)
  qb [perfect conductor] = circle(normal=Z, centre=(0um, 0um, 0um), radius=qb_r) in RelativeCS1
  Polyline2 = polyline((0um, cp_r-cp_gap, 0um) (0um, qb_r, 0um)) in RelativeCS1
  Polyline2.sweep_around_axis(axis=Z, angle=cp_angle) in RelativeCS1
  Polyline2_1, Polyline2_2, Polyline2_3 = Polyline2.duplicate_around_axis(axis=Z, angle=spacing_angle + cp_angle, total=4) in RelativeCS1
  Polyline4 = polyline((0um, ro_r-ro_gap, 0um) (0um, qb_r, 0um)) in RelativeCS1
  Polyline4.sweep_around_axis(axis=Z, angle=ro_angle) in RelativeCS1
  Polyline4.rotate(axis=Z, angle=-spacing_angle-ro_angle) in RelativeCS1
  qb.subtract(Polyline2, Polyline2_1, Polyline2_2, Polyline2_3, Polyline4)
  cp1 [perfect conductor] = polyline((0um, cp_r, 0um) (0um, qb_r, 0um)) in RelativeCS1
  cp1.sweep_around_axis(axis=Z, angle=cp_angle) in RelativeCS1
  Rectangle1 = rectangle(corner=(0um, 0um, 0um), x_size=-cp_gap, y_size=qb_r+5um) in RelativeCS1
  Rectangle1_1 = Rectangle1.duplicate_mirror(point=(0um, 0um, 0um), normal=(-1um, 0um, 0um)) in RelativeCS1
  Rectangle1_1.rotate(axis=Z, angle=cp_angle) in RelativeCS1
  Rectangle1_1.unite(Rectangle1)
  cp1.subtract(Rectangle1_1)
  cp2, cp3, cp4 [perfect conductor] = cp1.duplicate_around_axis(axis=Z, angle=spacing_angle + cp_angle, total=4) in RelativeCS1
  ro [perfect conductor] = polyline((0um, ro_r, 0um) (0um, qb_r, 0um)) in RelativeCS1
  ro.sweep_around_axis(axis=Z, angle=ro_angle) in RelativeCS1
  Rectangle2 = rectangle(corner=(0um, 0um, 0um), x_size=-ro_gap, y_size=qb_r+5um) in RelativeCS1
  Rectangle2_1 = Rectangle2.duplicate_mirror(point=(0um, 0um, 0um), normal=(-1um, 0um, 0um)) in RelativeCS1
  Rectangle2_1.rotate(axis=Z, angle=ro_angle) in RelativeCS1
  Rectangle2_1.unite(Rectangle2)
  ro.subtract(Rectangle2_1)
  ro.rotate(axis=Z, angle=-spacing_angle-ro_angle) in RelativeCS1
  sub_bot1 = box(corner=(-sub_X/2, -sub_Y/2, -sub_Z), size=(sub_X, sub_Y, sub_Z))
  sub_top1 = sub_bot1.duplicate_along_line(step=(0um, 0um, sub_Z+FC_z), total=2)
  MA_top [thin_layer_eps_r_num] = object_from(sub_top1.face(2 of 6))
  [sub_bot1, sub_top1].delete()
  coordinate_system RelativeCS2 = origin=(0um, 0um, FC_z) Euler Angle ZYZ phi=0deg theta=0deg psi=0deg
  Circle3 = circle(normal=Z, centre=(0um, 0um, 0um), radius=qb_r+qb_gap) in RelativeCS2
  MA_top.subtract(Circle3)
  qb1 = circle(normal=Z, centre=(0um, 0um, 0um), radius=qb_r) in RelativeCS2
  Polyline5 = polyline((0um, cp_r-cp_gap, 0um) (0um, qb_r, 0um)) in RelativeCS2
  Polyline5.sweep_around_axis(axis=Z, angle=cp_angle) in RelativeCS2
  Polyline2_4, Polyline2_5, Polyline2_6 = Polyline5.duplicate_around_axis(axis=Z, angle=spacing_angle + cp_angle, total=4) in RelativeCS2
  Polyline6 = polyline((0um, ro_r-ro_gap, 0um) (0um, qb_r, 0um)) in RelativeCS2
  Polyline6.sweep_around_axis(axis=Z, angle=ro_angle) in RelativeCS2
  Polyline6.rotate(axis=Z, angle=-spacing_angle-ro_angle) in RelativeCS2
  qb1.subtract(Polyline5, Polyline2_4, Polyline2_5, Polyline2_6, Polyline6)
  cp5 = polyline((0um, cp_r, 0um) (0um, qb_r, 0um)) in RelativeCS2
  cp5.sweep_around_axis(axis=Z, angle=cp_angle) in RelativeCS2
  Rectangle3 = rectangle(corner=(0um, 0um, 0um), x_size=-cp_gap, y_size=qb_r+5um) in RelativeCS2
  Rectangle1_2 = Rectangle3.duplicate_mirror(point=(0um, 0um, 0um), normal=(-1um, 0um, 0um)) in RelativeCS2
  Rectangle1_2.rotate(axis=Z, angle=cp_angle) in RelativeCS2
  Rectangle1_2.unite(Rectangle3)
  cp5.subtract(Rectangle1_2)
  cp6, cp7, cp8 = cp5.duplicate_around_axis(axis=Z, angle=spacing_angle + cp_angle, total=4) in RelativeCS2
  ro1 = polyline((0um, ro_r, 0um) (0um, qb_r, 0um)) in RelativeCS2
  ro1.sweep_around_axis(axis=Z, angle=ro_angle) in RelativeCS2
  Rectangle4 = rectangle(corner=(0um, 0um, 0um), x_size=-ro_gap, y_size=qb_r+5um) in RelativeCS2
  Rectangle2_2 = Rectangle4.duplicate_mirror(point=(0um, 0um, 0um), normal=(-1um, 0um, 0um)) in RelativeCS2
  Rectangle2_2.rotate(axis=Z, angle=ro_angle) in RelativeCS2
  Rectangle2_2.unite(Rectangle4)
  ro1.subtract(Rectangle2_2)
  ro1.rotate(axis=Z, angle=-spacing_angle-ro_angle) in RelativeCS2
  [MA_top, qb1, cp5, ro1, cp6, cp7, cp8].sweep_along_vector((0um, 0um, -lossy_layer_thickness))
  MA_top.unite(qb1, cp5, ro1, cp6, cp7, cp8)
  sub_bot2 = box(corner=(-sub_X/2, -sub_Y/2, -sub_Z), size=(sub_X, sub_Y, sub_Z))
  sub_top2 = sub_bot2.duplicate_along_line(step=(0um, 0um, sub_Z+FC_z), total=2)
  MS_top [thin_layer_eps_r_num] = object_from(sub_top2.face(2 of 6))
  [sub_bot2, sub_top2].delete()
  coordinate_system RelativeCS3 = origin=(0um, 0um, FC_z) Euler Angle ZYZ phi=0deg theta=0deg psi=0deg
  Circle4 = circle(normal=Z, centre=(0um, 0um, 0um), radius=qb_r+qb_gap) in RelativeCS3
  MS_top.subtract(Circle4)
  qb2 = circle(normal=Z, centre=(0um, 0um, 0um), radius=qb_r) in RelativeCS3
  Polyline7 = polyline((0um, cp_r-cp_gap, 0um) (0um, qb_r, 0um)) in RelativeCS3
  Polyline7.sweep_around_axis(axis=Z, angle=cp_angle) in RelativeCS3
  Polyline2_7, Polyline2_8, Polyline2_9 = Polyline7.duplicate_around_axis(axis=Z, angle=spacing_angle + cp_angle, total=4) in RelativeCS3
  Polyline8 = polyline((0um, ro_r-ro_gap, 0um) (0um, qb_r, 0um)) in RelativeCS3
  Polyline8.sweep_around_axis(axis=Z, angle=ro_angle) in RelativeCS3
  Polyline8.rotate(axis=Z, angle=-spacing_angle-ro_angle) in RelativeCS3
  qb2.subtract(Polyline7, Polyline2_7, Polyline2_8, Polyline2_9, Polyline8)
  cp9 = polyline((0um, cp_r, 0um) (0um, qb_r, 0um)) in RelativeCS3
  cp9.sweep_around_axis(axis=Z, angle=cp_angle) in RelativeCS3
  Rectangle5 = rectangle(corner=(0um, 0um, 0um), x_size=-cp_gap, y_size=qb_r+5um) in RelativeCS3
  Rectangle1_3 = Rectangle5.duplicate_mirror(point=(0um, 0um, 0um), normal=(-1um, 0um, 0um)) in RelativeCS3
  Rectangle1_3.rotate(axis=Z, angle=cp_angle) in RelativeCS3
  Rectangle1_3.unite(Rectangle5)
  cp9.subtract(Rectangle1_3)
  cp10, cp11, cp12 = cp9.duplicate_around_axis(axis=Z, angle=spacing_angle + cp_angle, total=4) in RelativeCS3
  ro2 = polyline((0um, ro_r, 0um) (0um, qb_r, 0um)) in RelativeCS3
  ro2.sweep_around_axis(axis=Z, angle=ro_angle) in RelativeCS3
  Rectangle6 = rectangle(corner=(0um, 0um, 0um), x_size=-ro_gap, y_size=qb_r+5um) in RelativeCS3
  Rectangle2_3 = Rectangle6.duplicate_mirror(point=(0um, 0um, 0um), normal=(-1um, 0um, 0um)) in RelativeCS3
  Rectangle2_3.rotate(axis=Z, angle=ro_angle) in RelativeCS3
  Rectangle2_3.unite(Rectangle6)
  ro2.subtract(Rectangle2_3)
  ro2.rotate(axis=Z, angle=-spacing_angle-ro_angle) in RelativeCS3
  [MS_top, qb2, cp9, ro2, cp10, cp11, cp12].sweep_along_vector((0um, 0um, lossy_layer_thickness))
  MS_top.unite(qb2, cp9, ro2, cp10, cp11, cp12)
  SA_top [thin_layer_eps_r_num] = object_from(sub_top.face(2 of 6))
  SA_top.sweep_along_vector((0um, 0um, lossy_layer_thickness))
  SA_top_1 = SA_top.copy()
  sub_top.subtract(SA_top_1)
  MS_top_1 = MS_top.copy()
  SA_top.subtract(MS_top_1)
  Rectangle7 = rectangle(corner=(-JJ_w/2, qb_r-2um, 10um), x_size=JJ_w, y_size=4um)
  Rectangle8 = rectangle(corner=(-JJ_w/2, qb_r+2um, 10um), x_size=JJ_w, y_size=qb_gap-4um)
  Rectangle9 = rectangle(corner=(-JJ_w/2, qb_r +qb_gap-2um, 10um), x_size=JJ_w, y_size=4um)
  [Rectangle7, Rectangle8, Rectangle9].rotate(axis=Z, angle=-spacing_angle/2)
  qb.unite(Rectangle7)
  GND_top.unite(Rectangle9)
  GND_bot [silicon1] = object_from(sub_bot.face(+z))
  MA_bot [thin_layer_eps_r_num] = object_from(GND_bot.face)
  MA_bot.sweep_along_vector((0um, 0um, lossy_layer_thickness))
boundaries and excitations:
  PerfE1: Perfect E Objects=[cp1..cp4, GND_top, qb, ro, GND_bot]
  LumpRLC1: Lumped RLC Objects=Rectangle8 CurrentLine{middle of Rectangle8.edge(1 of 4) -> middle of Rectangle8.edge(3 of 4)} Inductance=L_JJ
mesh:
  ApplyCurvilinear1: Curvilinear Objects=[MA_top, MS_top, SA_top, MA_bot] Apply
setups:
  Setup1: HfssEigen MinimumFrequency=3GHz NumModes=1 MaxDeltaFreq=1 ConvergeOnRealFreq=false MaximumPasses=2 MinimumPasses=1 MinimumConvergedPasses=1 PercentRefinement=30 BasisOrder=-1 ExpressionCache{CacheItem{Title=E_MA1 Expression=E_MA TraceID=427 ReportType=5} CacheItem{Title=E_SA1 Expression=E_SA TraceID=428 ReportType=5} CacheItem{Title=E_MS1 Expression=E_MS TraceID=429 ReportType=5} CacheItem{Title=E_sub_bot1 Expression=E_sub_bot TraceID=430 ReportType=5} CacheItem{Title=E_sub_top1 Expression=E_sub_top TraceID=431 ReportType=5} CacheItem{Title=E_vac1 Expression=E_vac TraceID=432 ReportType=5} CacheItem{Title=E_tot1 Expression=E_tot TraceID=433 ReportType=5} CacheItem{Title=p_MA1 Expression=p_MA IsConvergence UseRelativeConvergence=1 MaxConvergenceDelta=2 MaxConvergeValue=0.01 TraceID=440 ReportType=5} CacheItem{Title=p_SA1 Expression=p_SA IsConvergence UseRelativeConvergence=1 MaxConvergenceDelta=2 MaxConvergeValue=0.01 TraceID=441 ReportType=5} CacheItem{Title=p_MS1 Expression=p_MS IsConvergence UseRelativeConvergence=1 MaxConvergenceDelta=2 MaxConvergeValue=0.01 TraceID=442 ReportType=5} CacheItem{Title=p_sub_bot1 Expression=p_sub_bot IsConvergence UseRelativeConvergence=1 MaxConvergenceDelta=2 MaxConvergeValue=0.01 TraceID=443 ReportType=5} CacheItem{Title=p_sub_top1 Expression=p_sub_top IsConvergence UseRelativeConvergence=1 MaxConvergenceDelta=2 MaxConvergeValue=0.01 TraceID=444 ReportType=5} CacheItem{Title=p_vac1 Expression=p_vac IsConvergence UseRelativeConvergence=1 MaxConvergenceDelta=2 MaxConvergeValue=0.01 TraceID=445 ReportType=5}}
source amplitudes:
  #-10:1: 1 0deg
optimetrics:
  ParametricSetup1: Parametric Sim._Setups=[Setup1]
    sweep lossy_layer_thickness: LINC 0.2um 0.5um 1
    calculate re(Mode(1)) on Setup1 : LastAdaptive
field calculator expressions:
  E_norm = Fundamental_Quantity(0) | Fundamental_Quantity(0) | Conj | Dot | Real
  E_X = Fundamental_Quantity(0) | Vector_Constant(1, 0, 0) | Dot | Fundamental_Quantity(0) | Vector_Constant(1, 0, 0) | Dot | Conj | * | Real
  E_Y = Fundamental_Quantity(0) | Vector_Constant(0, 1, 0) | Dot | Fundamental_Quantity(0) | Vector_Constant(0, 1, 0) | Dot | Conj | * | Real
  E_Z = Fundamental_Quantity(0) | Vector_Constant(0, 0, 1) | Dot | Fundamental_Quantity(0) | Vector_Constant(0, 0, 1) | Dot | Conj | * | Real
  E_MA_bot_P = E_X | EnterVolume(MA_bot) | VolumeValue | Integrate | E_Y | EnterVolume(MA_bot) | VolumeValue | Integrate | +
  E_MA_top_P = E_X | EnterVolume(MA_top) | VolumeValue | Integrate | E_Y | EnterVolume(MA_top) | VolumeValue | Integrate | +
  E_MA_P = E_MA_bot_P | E_MA_top_P | +
  E_MA_bot_O = E_Z | EnterVolume(MA_bot) | VolumeValue | Integrate
  E_MA_top_O = E_Z | EnterVolume(MA_top) | VolumeValue | Integrate
  E_MA_O = E_MA_bot_O | E_MA_top_O | +
  E_MA = E_MA_O | 3.3 | /
  E_SA_P = E_X | EnterVolume(SA_top) | VolumeValue | Integrate | E_Y | EnterVolume(SA_top) | VolumeValue | Integrate | +
  E_SA_O = E_Z | EnterVolume(SA_top) | VolumeValue | Integrate
  E_SA = E_SA_O | 0.45 | / | E_SA_P | 0.45 | * | +
  E_MS_P = E_X | EnterVolume(MS_top) | VolumeValue | Integrate | E_Y | EnterVolume(MS_top) | VolumeValue | Integrate | +
  E_MS_O = E_Z | EnterVolume(MS_top) | VolumeValue | Integrate
  E_MS = E_MS_O | 1.145 | /
  E_sub_bot = E_norm | EnterVolume(sub_bot) | VolumeValue | Integrate | 11.45 | *
  E_sub_top = E_norm | EnterVolume(sub_top) | VolumeValue | Integrate | 11.45 | *
  E_vac = E_norm | EnterVolume(Region) | VolumeValue | Integrate | 1 | *
  E_tot = E_MA | E_SA | E_MS | E_sub_bot | E_sub_top | E_vac | + | + | + | + | +
  p_MA = E_MA | E_tot | /
  p_SA = E_SA | E_tot | /
  p_MS = E_MS | E_tot | /
  p_sub_bot = E_sub_bot | E_tot | /
  p_sub_top = E_sub_top | E_tot | /
  p_vac = E_vac | E_tot | /

design maxwell_design (Maxwell 3D, Electrostatic, model units um)
variables:
  sub_X = 2000um
  sub_Y = sub_X
  sub_Z = 550um
  ro_r = 1e+6*(ro_alpha*(ro_r_crit+5um)+(1-ro_alpha)*(qb_r-10um)) um
  FC_z = 10um
  qb_r = cp_r_crit+qb_r_delta
  qb_gap = 15um
  cp_alpha = 0.5  # optimise 0.1..0.9
  cp_gap = 15um
  cp_angle = 60deg  # optimise 20deg..60deg
  cp_r_crit = cp_gap/sin(cp_angle/2)
  ro_gap = cp_gap
  ro_angle = cp_angle
  ro_r_crit = ro_gap/sin(ro_angle/2)
  cp_r = cp_alpha*(cp_r_crit+5um)+(1-cp_alpha)*(qb_r-10um)
  ro_alpha = cp_alpha
  spacing_angle = (360 deg - 4 * cp_angle - ro_angle) /5
  sc_z = 0.15um
  qb_r_delta = 40um  # optimise 20um..60um
geometry:
  sub_bot [silicon1] = box(corner=(-sub_X/2, -sub_Y/2, -sub_Z), size=(sub_X, sub_Y, sub_Z))
  sub_top [silicon1] = sub_bot.duplicate_along_line(step=(0um, 0um, sub_Z+FC_z), total=2)
  coordinate_system RelativeCS1 = origin=(0um, 0um, FC_z) Euler Angle ZYZ phi=0deg theta=0deg psi=0deg
  Region [vacuum] = region(+X=0 percentage offset, -X=0 percentage offset, +Y=0 percentage offset, -Y=0 percentage offset, +Z=500um absolute offset, -Z=500um absolute offset) in RelativeCS1
  GND_top [perfect conductor] = object_from(sub_top.face(2 of 6))
  qb [perfect conductor] = circle(normal=Z, centre=(0um, 0um, 0um), radius=qb_r) in RelativeCS1
  Circle2 = circle(normal=Z, centre=(0um, 0um, 0um), radius=qb_r+qb_gap) in RelativeCS1
  GND_top.subtract(Circle2)
  cp1 [perfect conductor] = polyline((0um, cp_r, 0um) (0um, qb_r, 0um)) in RelativeCS1
  Polyline2 = polyline((0um, cp_r-cp_gap, 0um) (0um, qb_r, 0um)) in RelativeCS1
  [cp1, Polyline2].sweep_around_axis(axis=Z, angle=cp_angle) in RelativeCS1
  Rectangle1 = rectangle(corner=(0um, 0um, 0um), x_size=-cp_gap, y_size=qb_r+5um) in RelativeCS1
  Rectangle1_1 = Rectangle1.duplicate_mirror(point=(0um, 0um, 0um), normal=(-1um, 0um, 0um)) in RelativeCS1
  Rectangle1_1.rotate(axis=Z, angle=cp_angle) in RelativeCS1
  Rectangle1_1.unite(Rectangle1)
  cp1.subtract(Rectangle1_1)
  Polyline2_1, Polyline2_2, Polyline2_3 = Polyline2.duplicate_around_axis(axis=Z, angle=spacing_angle + cp_angle, total=4) in RelativeCS1
  ro [perfect conductor] = polyline((0um, ro_r, 0um) (0um, qb_r, 0um)) in RelativeCS1
  Polyline4 = polyline((0um, ro_r-ro_gap, 0um) (0um, qb_r, 0um)) in RelativeCS1
  [ro, Polyline4].sweep_around_axis(axis=Z, angle=ro_angle) in RelativeCS1
  Rectangle2 = rectangle(corner=(0um, 0um, 0um), x_size=-ro_gap, y_size=qb_r+5um) in RelativeCS1
  Rectangle2_1 = Rectangle2.duplicate_mirror(point=(0um, 0um, 0um), normal=(-1um, 0um, 0um)) in RelativeCS1
  Rectangle2_1.rotate(axis=Z, angle=ro_angle) in RelativeCS1
  Rectangle2_1.unite(Rectangle2)
  ro.subtract(Rectangle2_1)
  [ro, Polyline4].rotate(axis=Z, angle=-spacing_angle-ro_angle) in RelativeCS1
  cp2, cp3, cp4 [perfect conductor] = cp1.duplicate_around_axis(axis=Z, angle=spacing_angle + cp_angle, total=4) in RelativeCS1
  qb.subtract(Polyline2, Polyline2_1, Polyline2_2, Polyline2_3, Polyline4)
  [cp1, ro, cp2, cp3, cp4, qb, GND_top].sweep_along_vector((0um, 0um, -sc_z)) in RelativeCS1
  GND_bot [perfect conductor] = object_from(sub_bot.face(+z))
  GND_bot.thicken(sc_z)
boundaries and excitations:
  V_qb: Voltage Objects=qb Voltage=1mV
  V_cp1: Voltage Objects=cp1 Voltage=-1mV
  V_cp2: Voltage Objects=cp2 Voltage=-1mV
  V_cp3: Voltage Objects=cp3 Voltage=-1mV
  V_cp4: Voltage Objects=cp4 Voltage=-1mV
  V_ro: Voltage Objects=ro Voltage=-2mV
  V_GND_bot: Voltage Objects=GND_bot Voltage=0mV
  V_GND_top: Voltage Objects=GND_top Voltage=0mV
parameters:
  Matrix1: Matrix V_cp1..V_cp4, V_GND_bot, V_qb, V_ro, V_GND_top: NumberOfTurns=1
mesh:
  VACUUM: LengthBased RefineInside Objects=Region MaxLength=700um
  SUBS: LengthBased RefineInside Objects=[sub_top, sub_bot] MaxLength=650um
  CPs: LengthBased Objects=[cp1..cp4] MaxLength=12um
  RO: LengthBased Objects=ro MaxLength=14um
  QB: LengthBased Objects=qb MaxLength=13um
  GND: LengthBased Objects=[GND_top, GND_bot] MaxLength=350um
  ApplyCurvilinear1: Curvilinear Objects=[cp1..cp4, GND_top, qb, ro] Apply
  initial mesh: GlobalCurvilinear{Apply}
setups:
  Setup1: Electrostatic MaximumPasses=1 MinimumPasses=1 MinimumConvergedPasses=1 PercentRefinement=30 PercentError=5 ExpressionCache{CacheItem{Title=Matrix1_C_V_qb_V_qb_1 Expression=Matrix1.C(V_qb,V_qb) IsConvergence UseRelativeConvergence=1 MaxConvergenceDelta=1.5 MaxConvergeValue=0.01 TraceID=972 ReportType=0} CacheItem{Title=Matrix1_C_V_qb_V_cp1_1 Expression=Matrix1.C(V_qb,V_cp1) IsConvergence UseRelativeConvergence=1 MaxConvergenceDelta=1.5 MaxConvergeValue=0.01 TraceID=973 ReportType=0} CacheItem{Title=Matrix1_C_V_qb_V_cp2_1 Expression=Matrix1.C(V_qb,V_cp2) IsConvergence UseRelativeConvergence=1 MaxConvergenceDelta=1.5 MaxConvergeValue=0.01 TraceID=974 ReportType=0} CacheItem{Title=Matrix1_C_V_qb_V_cp3_1 Expression=Matrix1.C(V_qb,V_cp3) IsConvergence UseRelativeConvergence=1 MaxConvergenceDelta=1.5 MaxConvergeValue=0.01 TraceID=975 ReportType=0} CacheItem{Title=Matrix1_C_V_qb_V_cp4_1 Expression=Matrix1.C(V_qb,V_cp4) IsConvergence UseRelativeConvergence=1 MaxConvergenceDelta=1.5 MaxConvergeValue=0.01 TraceID=976 ReportType=0} CacheItem{Title=Matrix1_C_V_qb_V_ro_1 Expression=Matrix1.C(V_qb,V_ro) IsConvergence UseRelativeConvergence=1 MaxConvergenceDelta=1.5 MaxConvergeValue=0.01 TraceID=977 ReportType=0}} RelativeResidual=1e-06 NonLinearResidual=0.001
optimetrics:
  OptimizationSetup1: Optimization Optimizer=SNLP AnalysisStopOptions{StopForNumIteration MaxNumIteration=2 MinNumIteration=10} CostFuncNormType=L2 Acceptable_Cost=0 Noise=0.0001 UpdateDesignWhenDone
    vary cp_alpha: Min=0.2 Max=0.8 MinStep=0.008 MaxStep=0.08 MinFocus=0.2 MaxFocus=0.8 start=0.5
    vary cp_angle: Min=30deg Max=60deg MinStep=0.5deg MaxStep=4deg MinFocus=30deg MaxFocus=60deg start=45deg
    vary qb_r_delta: Min=20um Max=300um MinStep=1um MaxStep=30um MinFocus=80um MaxFocus=250um start=150um
    goal Matrix1.C(V_qb,V_qb) == 1.1e-13 weight 1 on Setup1 : LastAdaptive
    goal Matrix1.C(V_qb,V_cp1) == -1e-14 weight 1 on Setup1 : LastAdaptive
