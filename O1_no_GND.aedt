# Ansys Electronics Desktop project, version 2019.3
materials:
  vacuum: permittivity=1
  silicon1: permittivity=11.45
  perfect conductor: conductivity=1e+30
  Nb2O5: permittivity=33
  SiO2: permittivity=4.5
  thin_layer_eps_r_num: permittivity=10

design hfss_design (HFSS, Eigenmode, model units um)
variables:
  sub_Y = sub_X
  sub_Z = 550um
  sub_X = 2000um
  CPW_W = 3um
  CPW_S = 5um
  FC_z = 10um
  ro_r = 40um
  ro_gap = qb_r+200um-ro_r
  ro_sl_l = 500um
  sc_z = 0.15um
  qb_r = r_crit+qb_r_delta
  ro_angle = 45deg
  qb_gap = 20um
  cp_sl_l = ro_sl_l
  cp_angle = 65deg
  cp_gap = 20um
  alpha_cp = 0.5
  r_crit = cp_gap/sin(cp_angle/2)
  lossy_layer_thickness = 0.4um
  JJ_w = 5um
  L_JJ = 9.2nH
  cp_r = cp_alpha*(r_crit+5um)+(1-cp_alpha)*(qb_r-10um)
  cp_alpha = 0.5
  qb_r_delta = 80um
geometry:
  coordinate_system RelativeCS1 = origin=(0um, 0um, FC_z) Euler Angle ZYZ phi=0deg theta=0deg psi=0deg
  coordinate_system RelativeCS2 = origin=(0um, 0um, FC_z) Euler Angle ZYZ phi=0deg theta=0deg psi=0deg
  coordinate_system RelativeCS3 = origin=(0um, 0um, FC_z) Euler Angle ZYZ phi=0deg theta=0deg psi=0deg in RelativeCS2
  sub_bot [silicon1] = box(corner=(-sub_X/2, -sub_Y/2, -sub_Z), size=(sub_X, sub_Y, sub_Z)) in RelativeCS2
  bot_GND [perfect conductor] = object_from(sub_bot.face(1 of 6))
  sub_top [silicon1] = sub_bot.duplicate_along_line(step=(0um, 0um, sub_Z+FC_z), total=2) in RelativeCS2
  Circle2 = circle(normal=Z, centre=(0um, 0um, 0um), radius=ro_r+ro_gap) in RelativeCS2
  bot_GND.subtract(Circle2)
  ro [perfect conductor] = circle(normal=Z, centre=(0um, 0um, 0um), radius=ro_r) in RelativeCS2
  top_GND [perfect conductor] = object_from(sub_top.face(2 of 6))
  coordinate_system RelativeCS4 = origin=(0um, 0um, FC_z) Euler Angle ZYZ phi=0deg theta=0deg psi=0deg in RelativeCS2
  Circle4 = circle(normal=Z, centre=(0um, 0um, 0um), radius=qb_r+qb_gap) in RelativeCS4
  top_GND.subtract(Circle4)
  qb [perfect conductor] = circle(normal=Z, centre=(0um, 0um, 0um), radius=qb_r) in RelativeCS4
  Polyline2 = polyline((0um, cp_r-cp_gap, 0um) (0um, qb_r, 0um)) in RelativeCS4
  Polyline2.sweep_around_axis(axis=Z, angle=cp_angle) in RelativeCS4
  Polyline2.rotate(axis=Z, angle=-cp_angle/2) in RelativeCS4
  Polyline2.duplicate_around_axis(axis=Z, angle=90deg, total=4, attached) in RelativeCS4
  qb.subtract(Polyline2)
  Region [vacuum] = region(+X=0 percentage offset, -X=0 percentage offset, +Y=0 percentage offset, -Y=0 percentage offset, +Z=500um absolute offset, -Z=500um absolute offset) in RelativeCS4
  cp1 [perfect conductor] = polyline((0um, cp_r, 0um) (0um, qb_r, 0um)) in RelativeCS4
  cp1.sweep_around_axis(axis=Z, angle=cp_angle) in RelativeCS4
  Rectangle6 = rectangle(corner=(0, 0um, 0um), x_size=-cp_gap, y_size=qb_r+qb_gap) in RelativeCS4
  Rectangle6_1 = Rectangle6.duplicate_mirror(point=(0um, 0um, 0um), normal=(-1um, 0um, 0um)) in RelativeCS4
  Rectangle6_1.rotate(axis=Z, angle=cp_angle) in RelativeCS4
  cp1.subtract(Rectangle6, Rectangle6_1)
  cp1.rotate(axis=Z, angle=-cp_angle/2) in RelativeCS4
  cp2, cp3, cp4 [perfect conductor] = cp1.duplicate_around_axis(axis=Z, angle=90deg, total=4) in RelativeCS4
  Rectangle7 = rectangle(corner=(-JJ_w/2, 0um, 0um), x_size=JJ_w, y_size=500um) in RelativeCS3
  Rectangle7.rotate(axis=Z, angle=-45deg) in RelativeCS2
  JJ = rectangle(corner=(-JJ_w/2, qb_r+2um, 0um), x_size=JJ_w, y_size=qb_gap-4um) in RelativeCS3
  JJ.rotate(axis=Z, angle=-45deg) in RelativeCS2
  Rectangle8_1 = JJ.copy()
  Rectangle7.subtract(Rectangle8_1)
  Rectangle7_Detach1 = Rectangle7.detach(top_GND.face(#8103))
  qb.unite(Rectangle7_Detach1)
  top_GND.unite(Rectangle7)
  coordinate_system RelativeCS5 = origin=(0um, 0um, FC_z) Euler Angle ZYZ phi=0deg theta=0deg psi=0deg in RelativeCS2
  coordinate_system RelativeCS6 = origin=(0um, 0um, FC_z) Euler Angle ZYZ phi=0deg theta=0deg psi=0deg in RelativeCS2
  coordinate_system RelativeCS7 = origin=(0um, 0um, FC_z) Euler Angle ZYZ phi=0deg theta=0deg psi=0deg in RelativeCS2
  SA_bot [thin_layer_eps_r_num] = object_from(sub_bot.face(1 of 6))
  SA_bot.thicken(-lossy_layer_thickness)
  MA_bot [thin_layer_eps_r_num] = object_from(bot_GND.face(at (0, 0, 10)))
  ro_ObjectFromFace1 = object_from(ro.face(at (0, 0, 10)))
  [MA_bot, ro_ObjectFromFace1].thicken(lossy_layer_thickness)
  MA_bot.unite(ro_ObjectFromFace1)
  sub_bot1 = box(corner=(-sub_X/2, -sub_Y/2, -sub_Z), size=(sub_X, sub_Y, sub_Z)) in RelativeCS2
  bot_GND1 = object_from(sub_bot1.face(1 of 6))
  Circle5 = circle(normal=Z, centre=(0um, 0um, 0um), radius=ro_r+ro_gap) in RelativeCS2
  bot_GND1.subtract(Circle5)
  MS_bot [thin_layer_eps_r_num] = object_from(bot_GND1.face(1 of 1))
  [sub_bot1, bot_GND1].delete()
  MS_bot.thicken(-lossy_layer_thickness)
  ro1 = circle(normal=Z, centre=(0um, 0um, 0um), radius=ro_r) in RelativeCS2
  ro_ObjectFromFace2 = object_from(ro1.face(#17034))
  ro_ObjectFromFace2.thicken(-lossy_layer_thickness)
  MS_bot.unite(ro_ObjectFromFace2)
  ro1.delete()
  bot_GND_ObjectFromFace2_1 = MS_bot.copy()
  sub_bot.subtract(bot_GND_ObjectFromFace2_1)
  bot_GND_ObjectFromFace2_2 = MS_bot.copy()
  SA_bot.subtract(bot_GND_ObjectFromFace2_2)
  bot_GND_ObjectFromFace2_3 = MS_bot.copy()
  sub_bot_ObjectFromFace1_1 = SA_bot.copy()
  sub_bot.subtract(bot_GND_ObjectFromFace2_3, sub_bot_ObjectFromFace1_1)
  top_GND_ObjectFromFace1 = object_from(top_GND.face(at (0, 0, 20)))
  cp4_ObjectFromFace1 = object_from(cp4.face(1 of 1))
  qb_ObjectFromFace1 = object_from(qb.face(at (0, 0, 20)))
  cp3_ObjectFromFace1 = object_from(cp3.face(1 of 1))
  cp2_ObjectFromFace1 = object_from(cp2.face(1 of 1))
  MS_top [thin_layer_eps_r_num] = object_from(cp1.face(#7580))
  [MS_top, cp2_ObjectFromFace1, cp3_ObjectFromFace1, cp4_ObjectFromFace1, qb_ObjectFromFace1, top_GND_ObjectFromFace1].sweep_along_vector((0um, 0um, lossy_layer_thickness)) in RelativeCS2
  MS_top.unite(cp2_ObjectFromFace1, cp3_ObjectFromFace1, cp4_ObjectFromFace1, qb_ObjectFromFace1, top_GND_ObjectFromFace1)
  coordinate_system RelativeCS9 = origin=(0um, 0um, FC_z) Euler Angle ZYZ phi=0deg theta=0deg psi=0deg in RelativeCS2
  cp5 = polyline((0um, cp_r, 0um) (0um, qb_r, 0um)) in RelativeCS9
  cp5.sweep_around_axis(axis=Z, angle=cp_angle) in RelativeCS9
  Rectangle8 = rectangle(corner=(0, 0um, 0um), x_size=-cp_gap, y_size=qb_r+qb_gap) in RelativeCS9
  Rectangle6_2 = Rectangle8.duplicate_mirror(point=(0um, 0um, 0um), normal=(-1um, 0um, 0um)) in RelativeCS9
  Rectangle6_2.rotate(axis=Z, angle=cp_angle) in RelativeCS9
  cp5.subtract(Rectangle8, Rectangle6_2)
  cp5.rotate(axis=Z, angle=-cp_angle/2) in RelativeCS9
  cp6, cp7, cp8 = cp5.duplicate_around_axis(axis=Z, angle=90deg, total=4) in RelativeCS9
  MA_top [thin_layer_eps_r_num] = object_from(cp5.face(#18031))
  cp5.delete()
  MA_top.sweep_along_vector((0um, 0um, lossy_layer_thickness)) in RelativeCS2
  coordinate_system RelativeCS8 = origin=(0um, 0um, FC_z) Euler Angle ZYZ phi=0deg theta=0deg psi=0deg in RelativeCS2
  cp2_ObjectFromFace2 = object_from(cp6.face)
  cp2_ObjectFromFace2.sweep_along_vector((0um, 0um, lossy_layer_thickness)) in RelativeCS2
  cp3_ObjectFromFace2 = object_from(cp7.face)
  cp3_ObjectFromFace2.sweep_along_vector((0um, 0um, lossy_layer_thickness)) in RelativeCS2
  cp4_ObjectFromFace2 = object_from(cp8.face)
  cp4_ObjectFromFace2.sweep_along_vector((0um, 0um, lossy_layer_thickness)) in RelativeCS2
  qb1 = circle(normal=Z, centre=(0um, 0um, 0um), radius=qb_r) in RelativeCS9
  Polyline3 = polyline((0um, cp_r-cp_gap, 0um) (0um, qb_r, 0um)) in RelativeCS9
  Polyline3.sweep_around_axis(axis=Z, angle=cp_angle) in RelativeCS9
  Polyline3.rotate(axis=Z, angle=-cp_angle/2) in RelativeCS9
  Polyline3.duplicate_around_axis(axis=Z, angle=90deg, total=4, attached) in RelativeCS9
  qb1.subtract(Polyline3)
  Rectangle9 = rectangle(corner=(-JJ_w/2, 0um, 0um), x_size=JJ_w, y_size=500um) in RelativeCS8
  Rectangle9.rotate(axis=Z, angle=-45deg) in RelativeCS2
  JJ1 = rectangle(corner=(-JJ_w/2, qb_r+2um, 0um), x_size=JJ_w, y_size=qb_gap-4um) in RelativeCS8
  JJ1.rotate(axis=Z, angle=-45deg) in RelativeCS2
  Rectangle8_2 = JJ1.copy()
  Rectangle9.subtract(Rectangle8_2)
  Rectangle7_Detach2 = Rectangle9.detach(top_GND1.face(#18169))
  qb1.unite(Rectangle7_Detach2)
  qb_ObjectFromFace2 = object_from(qb1.face(#17985))
  qb_ObjectFromFace2.sweep_along_vector((0um, 0um, lossy_layer_thickness)) in RelativeCS2
  sub_bot2 = box(corner=(-sub_X/2, -sub_Y/2, -sub_Z), size=(sub_X, sub_Y, sub_Z)) in RelativeCS2
  sub_top1 = sub_bot2.duplicate_along_line(step=(0um, 0um, sub_Z+FC_z), total=2) in RelativeCS2
  top_GND1 = object_from(sub_top1.face(2 of 6))
  Circle6 = circle(normal=Z, centre=(0um, 0um, 0um), radius=qb_r+qb_gap) in RelativeCS9
  top_GND1.subtract(Circle6)
  top_GND1.unite(Rectangle9)
  top_GND_ObjectFromFace2 = object_from(top_GND1.face(1 of 1))
  top_GND_ObjectFromFace2.sweep_along_vector((0um, 0um, lossy_layer_thickness)) in RelativeCS2
  MA_top.unite(cp2_ObjectFromFace2, cp3_ObjectFromFace2, cp4_ObjectFromFace2, qb_ObjectFromFace2, top_GND_ObjectFromFace2)
  [sub_bot2, sub_top1, top_GND1, qb1, cp6, cp7, cp8, JJ1].delete()
  MA_top.move(0um, 0um, -lossy_layer_thickness) in RelativeCS2
  SA_top [thin_layer_eps_r_num] = object_from(sub_top.face(2 of 6))
  SA_top.thicken(-lossy_layer_thickness)
  cp1_ObjectFromFace1_1 = MS_top.copy()
  SA_top.subtract(cp1_ObjectFromFace1_1)
boundaries and excitations:
  PerfE1: Perfect E Objects=[bot_GND, cp1..cp4, qb, ro, top_GND]
  LumpRLC1: Lumped RLC Objects=JJ CurrentLine{middle of JJ.edge(1 of 4) -> middle of JJ.edge(3 of 4)} Inductance=L_JJ
mesh:
  ApplyCurvilinear1: Curvilinear Objects=[MA_bot, MA_top, MS_bot, MS_top, SA_bot, SA_top] Apply
setups:
  Setup1: HfssEigen MinimumFrequency=3GHz NumModes=1 MaxDeltaFreq=1 ConvergeOnRealFreq=false MaximumPasses=2 MinimumPasses=1 MinimumConvergedPasses=1 PercentRefinement=30 BasisOrder=-1 ExpressionCache{CacheItem{Title=E_MA1 Expression=E_MA TraceID=2137 ReportType=5} CacheItem{Title=E_SA1 Expression=E_SA TraceID=2138 ReportType=5} CacheItem{Title=E_MS1 Expression=E_MS TraceID=2139 ReportType=5} CacheItem{Title=E_sub_bot1 Expression=E_sub_bot TraceID=2140 ReportType=5} CacheItem{Title=E_sub_top1 Expression=E_sub_top TraceID=2141 ReportType=5} CacheItem{Title=E_vac1 Expression=E_vac TraceID=2142 ReportType=5} CacheItem{Title=E_tot1 Expression=E_tot TraceID=2143 ReportType=5} CacheItem{Title=p_MA1 Expression=p_MA IsConvergence UseRelativeConvergence=1 MaxConvergenceDelta=2 MaxConvergeValue=0.01 TraceID=2150 ReportType=5} CacheItem{Title=p_SA1 Expression=p_SA IsConvergence UseRelativeConvergence=1 MaxConvergenceDelta=2 MaxConvergeValue=0.01 TraceID=2151 ReportType=5} CacheItem{Title=p_MS1 Expression=p_MS IsConvergence UseRelativeConvergence=1 MaxConvergenceDelta=2 MaxConvergeValue=0.01 TraceID=2152 ReportType=5} CacheItem{Title=p_sub_bot1 Expression=p_sub_bot IsConvergence UseRelativeConvergence=1 MaxConvergenceDelta=2 MaxConvergeValue=0.01 TraceID=2153 ReportType=5} CacheItem{Title=p_sub_top1 Expression=p_sub_top IsConvergence UseRelativeConvergence=1 MaxConvergenceDelta=2 MaxConvergeValue=0.01 TraceID=2154 ReportType=5} CacheItem{Title=p_vac1 Expression=p_vac IsConvergence UseRelativeConvergence=1 MaxConvergenceDelta=2 MaxConvergeValue=0.01 TraceID=2155 ReportType=5}}
source amplitudes:
  #-10:1: 1 0deg
optimetrics:
  ParametricSetup1: Parametric Sim._Setups=[Setup1]
    sweep lossy_layer_thickness: LINC 0.2um 0.5um 1
    calculate re(Mode(1)) on Setup1 : LastAdaptive
field calculator expressions:
  E_norm = Fundamental_Quantity(0) | Fundamental_Quantity(0) | Conj | Dot | Real
  E_X = Fundamental_Quantity(0) | Vector_Constant(1, 0, 0) | Dot | Fundamental_Quantity(0) | Vector_Constant(1, 0, 0) | Dot | Conj | * | Real
  E_Y = Fundamental_Quantity(0) | Vector_Constant(0, 1, 0) | Dot | Fundamental_Quantity(0) | Vector_Constant(0, 1, 0) | Dot | Conj | * | Real
  E_Z = Fundamental_Quantity(0) | Vector_Constant(0, 0, 1) | Dot | Fundamental_Quantity(0) | Vector_Constant(0, 0, 1) | Dot | Conj | * | Real
  E_MA_bot_P = E_X | EnterVolume(MA_bot) | VolumeValue | Integrate | E_Y | EnterVolume(MA_bot) | VolumeValue | Integrate | +
  E_MA_top_P = E_X | EnterVolume(MA_top) | VolumeValue | Integrate | E_Y | EnterVolume(MA_top) | VolumeValue | Integrate | +
  E_MA_P = E_MA_bot_P | E_MA_top_P | +
  E_MA_bot_O = E_Z | EnterVolume(MA_bot) | VolumeValue | Integrate
  E_MA_top_O = E_Z | EnterVolume(MA_top) | VolumeValue | Integrate
  E_MA_O = E_MA_bot_O | E_MA_top_O | +
  E_MA = E_MA_O | 3.3 | /
  E_SA_bot_P = E_X | EnterVolume(SA_bot) | VolumeValue | Integrate | E_Y | EnterVolume(SA_bot) | VolumeValue | Integrate | +
  E_SA_top_P = E_X | EnterVolume(SA_top) | VolumeValue | Integrate | E_Y | EnterVolume(SA_top) | VolumeValue | Integrate | +
  E_SA_P = E_SA_bot_P | E_SA_top_P | +
  E_SA_bot_O = E_Z | EnterVolume(SA_bot) | VolumeValue | Integrate
  E_SA_top_O = E_Z | EnterVolume(SA_top) | VolumeValue | Integrate
  E_SA_O = E_SA_bot_O | E_SA_top_O | +
  E_SA = E_SA_O | 0.45 | / | E_SA_P | 0.45 | * | +
  E_MS_bot_P = E_X | EnterVolume(MS_bot) | VolumeValue | Integrate | E_Y | EnterVolume(MS_bot) | VolumeValue | Integrate | +
  E_MS_top_P = E_X | EnterVolume(MS_top) | VolumeValue | Integrate | E_Y | EnterVolume(MS_top) | VolumeValue | Integrate | +
  E_MS_P = E_MS_bot_P | E_MS_top_P | +
  E_MS_bot_O = E_Z | EnterVolume(MS_bot) | VolumeValue | Integrate
  E_MS_top_O = E_Z | EnterVolume(MS_top) | VolumeValue | Integrate
  E_MS_O = E_MS_bot_O | E_MS_top_O | +
  E_MS = E_MS_O | 1.145 | /
  E_sub_bot = E_norm | EnterVolume(sub_bot) | VolumeValue | Integrate | 11.45 | *
  E_sub_top = E_norm | EnterVolume(sub_top) | VolumeValue | Integrate | 11.45 | *
  E_vac = E_norm | EnterVolume(Region) | VolumeValue | Integrate | 1 | *
  E_tot = E_MA | E_SA | E_MS | E_sub_bot | E_sub_top | E_vac | + | + | + | + | +
  p_MA = E_MA | E_tot | /
  p_SA = E_SA | E_tot | /
  p_MS = E_MS | E_tot | /
  p_sub_bot = E_sub_bot | E_tot | /
  p_sub_top = E_sub_top | E_tot | /
  p_vac = E_vac | E_tot | /

design maxwell_design (Maxwell 3D, Electrostatic, model units um)
variables:
  sub_X = 2000um
  sub_Y = sub_X
  sub_Z = 550um
  ro_r = 40um  # optimise 10um..70um
  ro_gap = qb_r+200um-ro_r
  CPW_S = 5um
  ro_sl_l = 500um
  CPW_W = 3um
  FC_z = 10um
  sc_z = 0.15um
  qb_r = r_crit + qb_r_delta
  qb_gap = 10um
  cp_gap = 10um
  cp_angle = 65deg
  r_crit = cp_gap/sin(cp_angle/2)
  cp_sl_l = ro_sl_l
  ro_angle = 45deg
  cp_r = cp_alpha*(r_crit+5um)+(1-cp_alpha)*(qb_r-10um)
  cp_alpha = 0.5  # optimise 0.1..0.9
  qb_r_delta = 80um  # optimise 40um..120um
  alpha_cp = 1  # optimise 0.2..0.9
geometry:
  sub_bot [silicon1] = box(corner=(-sub_X/2, -sub_Y/2, -sub_Z), size=(sub_X, sub_Y, sub_Z))
  bot_GND [perfect conductor] = object_from(sub_bot.face(+z))
  ro [perfect conductor] = circle(normal=Z, centre=(0um, 0um, 0um), radius=ro_r)
  Circle2 = circle(normal=Z, centre=(0um, 0um, 0um), radius=ro_r+ro_gap)
  sub_top [silicon1] = sub_bot.duplicate_along_line(step=(0um, 0um, sub_Z+FC_z), total=2)
  top_GND [perfect conductor] = object_from(sub_top.face(2 of 6))
  coordinate_system RelativeCS1 = origin=(0um, 0um, FC_z) Euler Angle ZYZ phi=0deg theta=0deg psi=0deg
  qb [perfect conductor] = circle(normal=Z, centre=(0um, 0um, 0um), radius=qb_r) in RelativeCS1
  Circle4 = circle(normal=Z, centre=(0um, 0um, 0um), radius=qb_r+qb_gap) in RelativeCS1
  top_GND.subtract(Circle4)
  top_GND.thicken(sc_z)
  bot_GND.subtract(Circle2)
  [bot_GND, ro].thicken(sc_z)
  Region [vacuum] = region(+X=0 percentage offset, -X=0 percentage offset, +Y=0 percentage offset, -Y=0 percentage offset, +Z=500um absolute offset, -Z=500um absolute offset) in RelativeCS1
  cp1 [perfect conductor] = polyline((0um, cp_r, 0um) (0um, qb_r, 0um)) in RelativeCS1
  cp1.sweep_around_axis(axis=Z, angle=cp_angle) in RelativeCS1
  Rectangle6 = rectangle(corner=(0, 0um, 0um), x_size=-cp_gap, y_size=qb_r+qb_gap) in RelativeCS1
  Rectangle6_1 = Rectangle6.duplicate_mirror(point=(0um, 0um, 0um), normal=(-1um, 0um, 0um)) in RelativeCS1
  Rectangle6_1.rotate(axis=Z, angle=cp_angle) in RelativeCS1
  Polyline2 = polyline((0um, cp_r-cp_gap, 0um) (0um, qb_r, 0um)) in RelativeCS1
  Polyline2.sweep_around_axis(axis=Z, angle=cp_angle) in RelativeCS1
  cp1.subtract(Rectangle6, Rectangle6_1)
  [Polyline2, cp1].rotate(axis=Z, angle=-cp_angle/2) in RelativeCS1
  Polyline2.duplicate_around_axis(axis=Z, angle=90deg, total=4, attached) in RelativeCS1
  qb.subtract(Polyline2)
  cp2, cp3, cp4 [perfect conductor] = cp1.duplicate_around_axis(axis=Z, angle=90deg, total=4) in RelativeCS1
  [qb, cp1..cp4].thicken(-sc_z)
boundaries and excitations:
  V_qb: Voltage Objects=qb Voltage=1mV
  V_top_GND: Voltage Objects=top_GND Voltage=0mV
  V_bot_GND: Voltage Objects=bot_GND Voltage=0mV
  V_ro: Voltage Objects=ro Voltage=-2mV
  V_cp1: Voltage Objects=cp1 Voltage=-1mV
  V_cp2: Voltage Objects=cp2 Voltage=-1mV
  V_cp3: Voltage Objects=cp3 Voltage=-1mV
  V_cp4: Voltage Objects=cp4 Voltage=-1mV
parameters:
  Matrix1: Matrix V_bot_GND, V_qb, V_ro, V_top_GND, V_cp1..V_cp4: NumberOfTurns=1
mesh:
  GNDs: LengthBased Objects=[top_GND, bot_GND] MaxLength=350um
  RO: LengthBased Objects=ro MaxLength=14um
  QB: LengthBased Objects=qb MaxLength=13um
  VACUUM: LengthBased RefineInside Objects=Region MaxLength=700um
  SUBS: LengthBased RefineInside Objects=[sub_top, sub_bot] MaxLength=650um
  CPs: LengthBased Objects=[cp1..cp4] MaxLength=12um
  ApplyCurvilinear1: Curvilinear Objects=[bot_GND, cp1..cp4, qb, ro, top_GND] Apply
  initial mesh: GlobalCurvilinear{Apply}
setups:
  Setup1: Electrostatic MaximumPasses=30 MinimumPasses=5 MinimumConvergedPasses=1 PercentRefinement=30 PercentError=5 ExpressionCache{CacheItem{Title=Matrix1_C_V_qb_V_qb_1 Expression=Matrix1.C(V_qb,V_qb) IsConvergence UseRelativeConvergence=1 MaxConvergenceDelta=1.5 MaxConvergeValue=0.01 TraceID=1166 ReportType=0} CacheItem{Title=Matrix1_C_V_qb_V_cp1_1 Expression=Matrix1.C(V_qb,V_cp1) IsConvergence UseRelativeConvergence=1 MaxConvergenceDelta=1.5 MaxConvergeValue=0.01 TraceID=1167 ReportType=0} CacheItem{Title=Matrix1_C_V_qb_V_cp2_1 Expression=Matrix1.C(V_qb,V_cp2) IsConvergence UseRelativeConvergence=1 MaxConvergenceDelta=1.5 MaxConvergeValue=0.01 TraceID=1168 ReportType=0} CacheItem{Title=Matrix1_C_V_qb_V_cp3_1 Expression=Matrix1.C(V_qb,V_cp3) IsConvergence UseRelativeConvergence=1 MaxConvergenceDelta=1.5 MaxConvergeValue=0.01 TraceID=1169 ReportType=0} CacheItem{Title=Matrix1_C_V_qb_V_cp4_1 Expression=Matrix1.C(V_qb,V_cp4) IsConvergence UseRelativeConvergence=1 MaxConvergenceDelta=1.5 MaxConvergeValue=0.01 TraceID=1170 ReportType=0} CacheItem{Title=Matrix1_C_V_qb_V_ro_1 Expression=Matrix1.C(V_qb,V_ro) IsConvergence UseRelativeConvergence=1 MaxConvergenceDelta=1.5 MaxConvergeValue=0.01 TraceID=1171 ReportType=0}} RelativeResidual=1e-06 NonLinearResidual=0.001
optimetrics:
  OptimizationSetup1: Optimization Optimizer=SNLP AnalysisStopOptions{StopForNumIteration MaxNumIteration=50 MinNumIteration=10} CostFuncNormType=L2 Acceptable_Cost=0 Noise=0.0001 UpdateDesignWhenDone
    vary cp_alpha: Min=0.2 Max=0.8 MinStep=0.008 MaxStep=0.08 MinFocus=0.2 MaxFocus=0.8 start=0.5
    vary qb_r_delta: Min=20um Max=300um MinStep=1um MaxStep=30um MinFocus=80um MaxFocus=250um start=150um
    vary ro_r: Min=20um Max=80um MinStep=0.5um MaxStep=30um MinFocus=20um MaxFocus=80um start=30um
    goal Matrix1.C(V_qb,V_qb) == 1.1e-13 weight 1 on Setup1 : LastAdaptive
    goal Matrix1.C(V_qb,V_cp1) == -1e-14 weight 1 on Setup1 : LastAdaptive
    goal Matrix1.C(V_qb,V_ro) == -1e-14 weight 1 on Setup1 : LastAdaptive
